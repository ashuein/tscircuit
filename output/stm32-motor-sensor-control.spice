* Circuit JSON to SPICE Netlist
CC_Y1 N3 0 20P
CC_Y2 N4 0 20P
CC1 N1 0 100N
CC2 N1 0 100N
CC3 N1 0 100N
CC_IMU1 N1 0 100N
CC_IMU2 N1 0 10N
CC_FDC N1 0 100N
CC_DRV1 N1 0 100N
CC_DRV2 N1 0 100N
CC_DRV3 N1 0 100N
CC_DRV4 N1 0 100N
CC_MOT1 N29 0 100U
CC_MOT2 N29 0 100U
CC_MOT3 N29 0 100U
CC_MOT4 N29 0 100U
CC_LDO_IN N42 0 10U
CC_LDO_OUT N1 0 10U
RR_SCL N1 N23 4.7K
RR_SDA N1 N24 4.7K
RR_LED N2 N43 1K
.END
